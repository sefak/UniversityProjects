# Ansys Electronics Desktop project, version 2020.2
project variables:
  $match_per = 22
  $muscle_per = 50
materials:
  Muscle: permittivity=$muscle_per conductivity=1.71
  matchmedium: permittivity=$match_per
  vacuum: permittivity=1

design Muscle_MatchMed (HFSS, DrivenTerminal, model units cm)
options: Allow_Material_Override open_region{BoundaryType=0 OpFreq=2.4GHz}
variables:
  # --Antenna Dimensions
  circ_rad = 1.1cm
  circ_wid = 0.2cm
  port_gap = 0.1cm
  turn_deg = (2*pi*circ_rad)/(2*pi*circ_rad+port_gap)*2*pi rad
  turn_z = 0deg
  # --Muscle and Matching Medium Dimensions
  muscle_dim = 4cm
  match_dim = 5cm
  match_wid = 1cm
  surface_dim = 1cm
geometry:
  RadiatingSurface [vacuum] = region(absolute_offset=4.1666667cm on all sides)
  Box1 [Muscle] = box(corner=(-1.5*muscle_dim, -1.5*muscle_dim, muscle_dim), size=(3*muscle_dim, 3*muscle_dim, -2*muscle_dim))
  Box2 [matchmedium] = box(corner=(-match_dim/2, -match_dim/2, muscle_dim), size=(match_dim, match_dim, match_wid))
  Rectangle1 [non-model] = rectangle(corner=(-surface_dim/2, -surface_dim*1.25, 0cm), x_size=surface_dim, y_size=surface_dim*2.5)
  Polyline1 = polyline(((circ_rad-circ_wid), 0, 0cm) (circ_rad, 0, 0cm))
  Polyline1.sweep_around_axis(axis=Z, angle=turn_deg-2*pi)
  Polyline1.rotate(axis=Z, angle=turn_z)
  Polyline1.move(0cm, 0cm, muscle_dim+match_wid)
  Polyline2 = polyline((circ_rad-circ_wid, 0, 0cm) (circ_rad, 0, 0cm))
  Polyline2.sweep_around_axis(axis=Z, angle=turn_deg)
  Polyline2.rotate(axis=Z, angle=turn_z)
  Polyline2.move(0cm, 0cm, muscle_dim+match_wid)
boundaries and excitations:
  AutoOpen1: Radiation Objects=RadiatingSurface
  PerfE1: Perfect E Objects=Polyline2
  Polyline2_T1: Terminal port=1 Edges=Polyline2.edge(1 of 1) TerminalResistance=50ohm
  1: Lumped Port Faces=Polyline1.face(#915) Impedance=50ohm
setups:
  ATK_Solution: HfssDriven Frequency=2.4GHz MaxDeltaS=0.02 MaximumPasses=15 MinimumPasses=1 MinimumConvergedPasses=1 PercentRefinement=30 BasisOrder=-1 PortAccuracy=2 IterativeResidual=1e-06 DDMSolverResidual=0.0001 IESolverType=ACA
    sweep FF_Sweep: point 2.4GHz; Type=Discrete SaveFields
    sweep SParam_Sweep: 2.2GHz to 2.6GHz, 21 points; Type=Interpolating InterpTolerance=0.5 InterpMaxSolns=250 PassivityErrorTolerance=0.0001
source amplitudes:
  1:1: 1 0deg
optimetrics:
  ParametricSetup1: Parametric Sim._Setups=[ATK_Solution]
    sweep $muscle_per: 20
    sweep $match_per: 1
    sweep circ_rad: 0.6cm
    sweep circ_wid: 0.1cm
    sweep port_gap: 0.1cm
    sweep turn_z: 0deg
    sweep muscle_dim: 4cm
    sweep match_dim: 5cm
    sweep match_wid: 0.5cm
    sweep surface_dim: 1cm
    table edits: add(20, 7, 0.6cm, 0.1cm, 0.1cm, 0deg, 4cm, 5cm, 0.5cm, 1cm) add(20, 14, 0.6cm, 0.1cm, 0.1cm, 0deg, 4cm, 5cm, 0.5cm, 1cm) add(30, 1, 0.6cm, 0.1cm, 0.1cm, 0deg, 4cm, 5cm, 0.5cm, 1cm) add(30, 8, 0.6cm, 0.1cm, 0.1cm, 0deg, 4cm, 5cm, 0.5cm, 1cm) add(30, 16, 0.6cm, 0.1cm, 0.1cm, 0deg, 4cm, 5cm, 0.5cm, 1cm) add(30, 23, 0.6cm, 0.1cm, 0.1cm, 0deg, 4cm, 5cm, 0.5cm, 1cm) add(40, 1, 0.6cm, 0.1cm, 0.1cm, 0deg, 4cm, 5cm, 0.5cm, 1cm) add(40, 9, 0.6cm, 0.1cm, 0.1cm, 0deg, 4cm, 5cm, 0.5cm, 1cm) add(40, 17, 0.6cm, 0.1cm, 0.1cm, 0deg, 4cm, 5cm, 0.5cm, 1cm) add(40, 24, 0.6cm, 0.1cm, 0.1cm, 0deg, 4cm, 5cm, 0.5cm, 1cm) add(40, 32, 0.6cm, 0.1cm, 0.1cm, 0deg, 4cm, 5cm, 0.5cm, 1cm)
  ParametricSetup2: Parametric Sim._Setups=[ATK_Solution]
    sweep $muscle_per: 50
    sweep $match_per: 1
    sweep circ_rad: 0.6cm
    sweep circ_wid: 0.1cm
    sweep port_gap: 0.1cm
    sweep turn_z: 0deg
    sweep muscle_dim: 4cm
    sweep match_dim: 5cm
    sweep match_wid: 0.5cm
    sweep surface_dim: 1cm
    table edits: add(50, 9, 0.6cm, 0.1cm, 0.1cm, 0deg, 4cm, 5cm, 0.5cm, 1cm) add(50, 17, 0.6cm, 0.1cm, 0.1cm, 0deg, 4cm, 5cm, 0.5cm, 1cm) add(50, 26, 0.6cm, 0.1cm, 0.1cm, 0deg, 4cm, 5cm, 0.5cm, 1cm) add(50, 34, 0.6cm, 0.1cm, 0.1cm, 0deg, 4cm, 5cm, 0.5cm, 1cm) add(50, 42, 0.6cm, 0.1cm, 0.1cm, 0deg, 4cm, 5cm, 0.5cm, 1cm) add(20, 1, 0.6cm, 0.1cm, 0.1cm, 0deg, 4cm, 5cm, 1cm, 1cm) add(20, 7, 0.6cm, 0.1cm, 0.1cm, 0deg, 4cm, 5cm, 1cm, 1cm) add(20, 14, 0.6cm, 0.1cm, 0.1cm, 0deg, 4cm, 5cm, 1cm, 1cm) add(30, 1, 0.6cm, 0.1cm, 0.1cm, 0deg, 4cm, 5cm, 1cm, 1cm) add(30, 8, 0.6cm, 0.1cm, 0.1cm, 0deg, 4cm, 5cm, 1cm, 1cm) add(30, 16, 0.6cm, 0.1cm, 0.1cm, 0deg, 4cm, 5cm, 1cm, 1cm)
  ParametricSetup3: Parametric Sim._Setups=[ATK_Solution]
    sweep $muscle_per: 30
    sweep $match_per: 23
    sweep circ_rad: 0.6cm
    sweep circ_wid: 0.1cm
    sweep port_gap: 0.1cm
    sweep turn_z: 0deg
    sweep muscle_dim: 4cm
    sweep match_dim: 5cm
    sweep match_wid: 1cm
    sweep surface_dim: 1cm
    table edits: add(40, 1, 0.6cm, 0.1cm, 0.1cm, 0deg, 4cm, 5cm, 1cm, 1cm) add(40, 9, 0.6cm, 0.1cm, 0.1cm, 0deg, 4cm, 5cm, 1cm, 1cm) add(40, 17, 0.6cm, 0.1cm, 0.1cm, 0deg, 4cm, 5cm, 1cm, 1cm) add(40, 24, 0.6cm, 0.1cm, 0.1cm, 0deg, 4cm, 5cm, 1cm, 1cm) add(40, 32, 0.6cm, 0.1cm, 0.1cm, 0deg, 4cm, 5cm, 1cm, 1cm) add(50, 1, 0.6cm, 0.1cm, 0.1cm, 0deg, 4cm, 5cm, 1cm, 1cm) add(50, 9, 0.6cm, 0.1cm, 0.1cm, 0deg, 4cm, 5cm, 1cm, 1cm) add(50, 17, 0.6cm, 0.1cm, 0.1cm, 0deg, 4cm, 5cm, 1cm, 1cm) add(50, 26, 0.6cm, 0.1cm, 0.1cm, 0deg, 4cm, 5cm, 1cm, 1cm) add(50, 34, 0.6cm, 0.1cm, 0.1cm, 0deg, 4cm, 5cm, 1cm, 1cm) add(50, 42, 0.6cm, 0.1cm, 0.1cm, 0deg, 4cm, 5cm, 1cm, 1cm)
  ParametricSetup4: Parametric Sim._Setups=[ATK_Solution]
    sweep $muscle_per: 20
    sweep $match_per: 1
    sweep circ_rad: 0.7cm
    sweep circ_wid: 0.1cm
    sweep port_gap: 0.1cm
    sweep turn_z: 0deg
    sweep muscle_dim: 4cm
    sweep match_dim: 5cm
    sweep match_wid: 0.5cm
    sweep surface_dim: 1cm
    table edits: add(20, 7, 0.7cm, 0.1cm, 0.1cm, 0deg, 4cm, 5cm, 0.5cm, 1cm) add(20, 14, 0.7cm, 0.1cm, 0.1cm, 0deg, 4cm, 5cm, 0.5cm, 1cm) add(30, 1, 0.7cm, 0.1cm, 0.1cm, 0deg, 4cm, 5cm, 0.5cm, 1cm) add(30, 8, 0.7cm, 0.1cm, 0.1cm, 0deg, 4cm, 5cm, 0.5cm, 1cm) add(30, 16, 0.7cm, 0.1cm, 0.1cm, 0deg, 4cm, 5cm, 0.5cm, 1cm) add(30, 23, 0.7cm, 0.1cm, 0.1cm, 0deg, 4cm, 5cm, 0.5cm, 1cm) add(40, 1, 0.7cm, 0.1cm, 0.1cm, 0deg, 4cm, 5cm, 0.5cm, 1cm) add(40, 9, 0.7cm, 0.1cm, 0.1cm, 0deg, 4cm, 5cm, 0.5cm, 1cm) add(40, 17, 0.7cm, 0.1cm, 0.1cm, 0deg, 4cm, 5cm, 0.5cm, 1cm) add(40, 24, 0.7cm, 0.1cm, 0.1cm, 0deg, 4cm, 5cm, 0.5cm, 1cm) add(40, 32, 0.7cm, 0.1cm, 0.1cm, 0deg, 4cm, 5cm, 0.5cm, 1cm)
  ParametricSetup5: Parametric Sim._Setups=[ATK_Solution]
    sweep $muscle_per: 50
    sweep $match_per: 1
    sweep circ_rad: 0.7cm
    sweep circ_wid: 0.1cm
    sweep port_gap: 0.1cm
    sweep turn_z: 0deg
    sweep muscle_dim: 4cm
    sweep match_dim: 5cm
    sweep match_wid: 0.5cm
    sweep surface_dim: 1cm
    table edits: add(50, 9, 0.7cm, 0.1cm, 0.1cm, 0deg, 4cm, 5cm, 0.5cm, 1cm) add(50, 17, 0.7cm, 0.1cm, 0.1cm, 0deg, 4cm, 5cm, 0.5cm, 1cm) add(50, 26, 0.7cm, 0.1cm, 0.1cm, 0deg, 4cm, 5cm, 0.5cm, 1cm) add(50, 34, 0.7cm, 0.1cm, 0.1cm, 0deg, 4cm, 5cm, 0.5cm, 1cm) add(50, 42, 0.7cm, 0.1cm, 0.1cm, 0deg, 4cm, 5cm, 0.5cm, 1cm) add(20, 1, 0.7cm, 0.1cm, 0.1cm, 0deg, 4cm, 5cm, 1cm, 1cm) add(20, 7, 0.7cm, 0.1cm, 0.1cm, 0deg, 4cm, 5cm, 1cm, 1cm) add(20, 14, 0.7cm, 0.1cm, 0.1cm, 0deg, 4cm, 5cm, 1cm, 1cm) add(30, 1, 0.7cm, 0.1cm, 0.1cm, 0deg, 4cm, 5cm, 1cm, 1cm) add(30, 8, 0.7cm, 0.1cm, 0.1cm, 0deg, 4cm, 5cm, 1cm, 1cm) add(30, 16, 0.7cm, 0.1cm, 0.1cm, 0deg, 4cm, 5cm, 1cm, 1cm)
  ParametricSetup6: Parametric Sim._Setups=[ATK_Solution]
    sweep $muscle_per: 30
    sweep $match_per: 23
    sweep circ_rad: 0.7cm
    sweep circ_wid: 0.1cm
    sweep port_gap: 0.1cm
    sweep turn_z: 0deg
    sweep muscle_dim: 4cm
    sweep match_dim: 5cm
    sweep match_wid: 1cm
    sweep surface_dim: 1cm
    table edits: add(40, 1, 0.7cm, 0.1cm, 0.1cm, 0deg, 4cm, 5cm, 1cm, 1cm) add(40, 9, 0.7cm, 0.1cm, 0.1cm, 0deg, 4cm, 5cm, 1cm, 1cm) add(40, 17, 0.7cm, 0.1cm, 0.1cm, 0deg, 4cm, 5cm, 1cm, 1cm) add(40, 24, 0.7cm, 0.1cm, 0.1cm, 0deg, 4cm, 5cm, 1cm, 1cm) add(40, 32, 0.7cm, 0.1cm, 0.1cm, 0deg, 4cm, 5cm, 1cm, 1cm) add(50, 1, 0.7cm, 0.1cm, 0.1cm, 0deg, 4cm, 5cm, 1cm, 1cm) add(50, 9, 0.7cm, 0.1cm, 0.1cm, 0deg, 4cm, 5cm, 1cm, 1cm) add(50, 17, 0.7cm, 0.1cm, 0.1cm, 0deg, 4cm, 5cm, 1cm, 1cm) add(50, 26, 0.7cm, 0.1cm, 0.1cm, 0deg, 4cm, 5cm, 1cm, 1cm) add(50, 34, 0.7cm, 0.1cm, 0.1cm, 0deg, 4cm, 5cm, 1cm, 1cm) add(50, 42, 0.7cm, 0.1cm, 0.1cm, 0deg, 4cm, 5cm, 1cm, 1cm)
  ParametricSetup7: Parametric Sim._Setups=[ATK_Solution]
    sweep $muscle_per: 20
    sweep $match_per: 1
    sweep circ_rad: 0.8cm
    sweep circ_wid: 0.1cm
    sweep port_gap: 0.1cm
    sweep turn_z: 0deg
    sweep muscle_dim: 4cm
    sweep match_dim: 5cm
    sweep match_wid: 0.5cm
    sweep surface_dim: 1cm
    table edits: add(20, 7, 0.8cm, 0.1cm, 0.1cm, 0deg, 4cm, 5cm, 0.5cm, 1cm) add(20, 14, 0.8cm, 0.1cm, 0.1cm, 0deg, 4cm, 5cm, 0.5cm, 1cm) add(30, 1, 0.8cm, 0.1cm, 0.1cm, 0deg, 4cm, 5cm, 0.5cm, 1cm) add(30, 8, 0.8cm, 0.1cm, 0.1cm, 0deg, 4cm, 5cm, 0.5cm, 1cm) add(30, 16, 0.8cm, 0.1cm, 0.1cm, 0deg, 4cm, 5cm, 0.5cm, 1cm) add(30, 23, 0.8cm, 0.1cm, 0.1cm, 0deg, 4cm, 5cm, 0.5cm, 1cm) add(40, 1, 0.8cm, 0.1cm, 0.1cm, 0deg, 4cm, 5cm, 0.5cm, 1cm) add(40, 9, 0.8cm, 0.1cm, 0.1cm, 0deg, 4cm, 5cm, 0.5cm, 1cm) add(40, 17, 0.8cm, 0.1cm, 0.1cm, 0deg, 4cm, 5cm, 0.5cm, 1cm) add(40, 24, 0.8cm, 0.1cm, 0.1cm, 0deg, 4cm, 5cm, 0.5cm, 1cm) add(40, 32, 0.8cm, 0.1cm, 0.1cm, 0deg, 4cm, 5cm, 0.5cm, 1cm)
  ParametricSetup8: Parametric Sim._Setups=[ATK_Solution]
    sweep $muscle_per: 50
    sweep $match_per: 1
    sweep circ_rad: 0.8cm
    sweep circ_wid: 0.1cm
    sweep port_gap: 0.1cm
    sweep turn_z: 0deg
    sweep muscle_dim: 4cm
    sweep match_dim: 5cm
    sweep match_wid: 0.5cm
    sweep surface_dim: 1cm
    table edits: add(50, 9, 0.8cm, 0.1cm, 0.1cm, 0deg, 4cm, 5cm, 0.5cm, 1cm) add(50, 17, 0.8cm, 0.1cm, 0.1cm, 0deg, 4cm, 5cm, 0.5cm, 1cm) add(50, 26, 0.8cm, 0.1cm, 0.1cm, 0deg, 4cm, 5cm, 0.5cm, 1cm) add(50, 34, 0.8cm, 0.1cm, 0.1cm, 0deg, 4cm, 5cm, 0.5cm, 1cm) add(50, 42, 0.8cm, 0.1cm, 0.1cm, 0deg, 4cm, 5cm, 0.5cm, 1cm) add(20, 1, 0.8cm, 0.1cm, 0.1cm, 0deg, 4cm, 5cm, 1cm, 1cm) add(20, 7, 0.8cm, 0.1cm, 0.1cm, 0deg, 4cm, 5cm, 1cm, 1cm) add(20, 14, 0.8cm, 0.1cm, 0.1cm, 0deg, 4cm, 5cm, 1cm, 1cm) add(30, 1, 0.8cm, 0.1cm, 0.1cm, 0deg, 4cm, 5cm, 1cm, 1cm) add(30, 8, 0.8cm, 0.1cm, 0.1cm, 0deg, 4cm, 5cm, 1cm, 1cm) add(30, 16, 0.8cm, 0.1cm, 0.1cm, 0deg, 4cm, 5cm, 1cm, 1cm)
  ParametricSetup9: Parametric Sim._Setups=[ATK_Solution]
    sweep $muscle_per: 30
    sweep $match_per: 23
    sweep circ_rad: 0.8cm
    sweep circ_wid: 0.1cm
    sweep port_gap: 0.1cm
    sweep turn_z: 0deg
    sweep muscle_dim: 4cm
    sweep match_dim: 5cm
    sweep match_wid: 1cm
    sweep surface_dim: 1cm
    table edits: add(40, 1, 0.8cm, 0.1cm, 0.1cm, 0deg, 4cm, 5cm, 1cm, 1cm) add(40, 9, 0.8cm, 0.1cm, 0.1cm, 0deg, 4cm, 5cm, 1cm, 1cm) add(40, 17, 0.8cm, 0.1cm, 0.1cm, 0deg, 4cm, 5cm, 1cm, 1cm) add(40, 24, 0.8cm, 0.1cm, 0.1cm, 0deg, 4cm, 5cm, 1cm, 1cm) add(40, 32, 0.8cm, 0.1cm, 0.1cm, 0deg, 4cm, 5cm, 1cm, 1cm) add(50, 1, 0.8cm, 0.1cm, 0.1cm, 0deg, 4cm, 5cm, 1cm, 1cm) add(50, 9, 0.8cm, 0.1cm, 0.1cm, 0deg, 4cm, 5cm, 1cm, 1cm) add(50, 17, 0.8cm, 0.1cm, 0.1cm, 0deg, 4cm, 5cm, 1cm, 1cm) add(50, 26, 0.8cm, 0.1cm, 0.1cm, 0deg, 4cm, 5cm, 1cm, 1cm) add(50, 34, 0.8cm, 0.1cm, 0.1cm, 0deg, 4cm, 5cm, 1cm, 1cm) add(50, 42, 0.8cm, 0.1cm, 0.1cm, 0deg, 4cm, 5cm, 1cm, 1cm)
  ParametricSetup10: Parametric Sim._Setups=[ATK_Solution]
    sweep $muscle_per: 20
    sweep $match_per: 1
    sweep circ_rad: 0.9cm
    sweep circ_wid: 0.2cm
    sweep port_gap: 0.1cm
    sweep turn_z: 0deg
    sweep muscle_dim: 4cm
    sweep match_dim: 5cm
    sweep match_wid: 0.5cm
    sweep surface_dim: 1cm
    table edits: add(20, 7, 0.9cm, 0.2cm, 0.1cm, 0deg, 4cm, 5cm, 0.5cm, 1cm) add(20, 14, 0.9cm, 0.2cm, 0.1cm, 0deg, 4cm, 5cm, 0.5cm, 1cm) add(30, 1, 0.9cm, 0.2cm, 0.1cm, 0deg, 4cm, 5cm, 0.5cm, 1cm) add(30, 8, 0.9cm, 0.2cm, 0.1cm, 0deg, 4cm, 5cm, 0.5cm, 1cm) add(30, 16, 0.9cm, 0.2cm, 0.1cm, 0deg, 4cm, 5cm, 0.5cm, 1cm) add(30, 23, 0.9cm, 0.2cm, 0.1cm, 0deg, 4cm, 5cm, 0.5cm, 1cm) add(40, 1, 0.9cm, 0.2cm, 0.1cm, 0deg, 4cm, 5cm, 0.5cm, 1cm) add(40, 9, 0.9cm, 0.2cm, 0.1cm, 0deg, 4cm, 5cm, 0.5cm, 1cm) add(40, 17, 0.9cm, 0.2cm, 0.1cm, 0deg, 4cm, 5cm, 0.5cm, 1cm) add(40, 24, 0.9cm, 0.2cm, 0.1cm, 0deg, 4cm, 5cm, 0.5cm, 1cm) add(40, 32, 0.9cm, 0.2cm, 0.1cm, 0deg, 4cm, 5cm, 0.5cm, 1cm)
  ParametricSetup11: Parametric Sim._Setups=[ATK_Solution]
    sweep $muscle_per: 50
    sweep $match_per: 1
    sweep circ_rad: 0.9cm
    sweep circ_wid: 0.2cm
    sweep port_gap: 0.1cm
    sweep turn_z: 0deg
    sweep muscle_dim: 4cm
    sweep match_dim: 5cm
    sweep match_wid: 0.5cm
    sweep surface_dim: 1cm
    table edits: add(50, 9, 0.9cm, 0.2cm, 0.1cm, 0deg, 4cm, 5cm, 0.5cm, 1cm) add(50, 17, 0.9cm, 0.2cm, 0.1cm, 0deg, 4cm, 5cm, 0.5cm, 1cm) add(50, 26, 0.9cm, 0.2cm, 0.1cm, 0deg, 4cm, 5cm, 0.5cm, 1cm) add(50, 34, 0.9cm, 0.2cm, 0.1cm, 0deg, 4cm, 5cm, 0.5cm, 1cm) add(50, 42, 0.9cm, 0.2cm, 0.1cm, 0deg, 4cm, 5cm, 0.5cm, 1cm) add(20, 1, 0.9cm, 0.2cm, 0.1cm, 0deg, 4cm, 5cm, 1cm, 1cm) add(20, 7, 0.9cm, 0.2cm, 0.1cm, 0deg, 4cm, 5cm, 1cm, 1cm) add(20, 14, 0.9cm, 0.2cm, 0.1cm, 0deg, 4cm, 5cm, 1cm, 1cm) add(30, 1, 0.9cm, 0.2cm, 0.1cm, 0deg, 4cm, 5cm, 1cm, 1cm) add(30, 8, 0.9cm, 0.2cm, 0.1cm, 0deg, 4cm, 5cm, 1cm, 1cm) add(30, 16, 0.9cm, 0.2cm, 0.1cm, 0deg, 4cm, 5cm, 1cm, 1cm)
  ParametricSetup12: Parametric Sim._Setups=[ATK_Solution]
    sweep $muscle_per: 30
    sweep $match_per: 23
    sweep circ_rad: 0.9cm
    sweep circ_wid: 0.2cm
    sweep port_gap: 0.1cm
    sweep turn_z: 0deg
    sweep muscle_dim: 4cm
    sweep match_dim: 5cm
    sweep match_wid: 1cm
    sweep surface_dim: 1cm
    table edits: add(40, 1, 0.9cm, 0.2cm, 0.1cm, 0deg, 4cm, 5cm, 1cm, 1cm) add(40, 9, 0.9cm, 0.2cm, 0.1cm, 0deg, 4cm, 5cm, 1cm, 1cm) add(40, 17, 0.9cm, 0.2cm, 0.1cm, 0deg, 4cm, 5cm, 1cm, 1cm) add(40, 24, 0.9cm, 0.2cm, 0.1cm, 0deg, 4cm, 5cm, 1cm, 1cm) add(40, 32, 0.9cm, 0.2cm, 0.1cm, 0deg, 4cm, 5cm, 1cm, 1cm) add(50, 1, 0.9cm, 0.2cm, 0.1cm, 0deg, 4cm, 5cm, 1cm, 1cm) add(50, 9, 0.9cm, 0.2cm, 0.1cm, 0deg, 4cm, 5cm, 1cm, 1cm) add(50, 17, 0.9cm, 0.2cm, 0.1cm, 0deg, 4cm, 5cm, 1cm, 1cm) add(50, 26, 0.9cm, 0.2cm, 0.1cm, 0deg, 4cm, 5cm, 1cm, 1cm) add(50, 34, 0.9cm, 0.2cm, 0.1cm, 0deg, 4cm, 5cm, 1cm, 1cm) add(50, 42, 0.9cm, 0.2cm, 0.1cm, 0deg, 4cm, 5cm, 1cm, 1cm)
  ParametricSetup13: Parametric Sim._Setups=[ATK_Solution]
    sweep $muscle_per: 20
    sweep $match_per: 1
    sweep circ_rad: 1cm
    sweep circ_wid: 0.2cm
    sweep port_gap: 0.1cm
    sweep turn_z: 0deg
    sweep muscle_dim: 4cm
    sweep match_dim: 5cm
    sweep match_wid: 0.5cm
    sweep surface_dim: 1cm
    table edits: add(20, 7, 1cm, 0.2cm, 0.1cm, 0deg, 4cm, 5cm, 0.5cm, 1cm) add(20, 14, 1cm, 0.2cm, 0.1cm, 0deg, 4cm, 5cm, 0.5cm, 1cm) add(30, 1, 1cm, 0.2cm, 0.1cm, 0deg, 4cm, 5cm, 0.5cm, 1cm) add(30, 8, 1cm, 0.2cm, 0.1cm, 0deg, 4cm, 5cm, 0.5cm, 1cm) add(30, 16, 1cm, 0.2cm, 0.1cm, 0deg, 4cm, 5cm, 0.5cm, 1cm) add(30, 23, 1cm, 0.2cm, 0.1cm, 0deg, 4cm, 5cm, 0.5cm, 1cm) add(40, 1, 1cm, 0.2cm, 0.1cm, 0deg, 4cm, 5cm, 0.5cm, 1cm) add(40, 9, 1cm, 0.2cm, 0.1cm, 0deg, 4cm, 5cm, 0.5cm, 1cm) add(40, 17, 1cm, 0.2cm, 0.1cm, 0deg, 4cm, 5cm, 0.5cm, 1cm) add(40, 24, 1cm, 0.2cm, 0.1cm, 0deg, 4cm, 5cm, 0.5cm, 1cm) add(40, 32, 1cm, 0.2cm, 0.1cm, 0deg, 4cm, 5cm, 0.5cm, 1cm)
  ParametricSetup14: Parametric Sim._Setups=[ATK_Solution]
    sweep $muscle_per: 50
    sweep $match_per: 1
    sweep circ_rad: 1cm
    sweep circ_wid: 0.2cm
    sweep port_gap: 0.1cm
    sweep turn_z: 0deg
    sweep muscle_dim: 4cm
    sweep match_dim: 5cm
    sweep match_wid: 0.5cm
    sweep surface_dim: 1cm
    table edits: add(50, 9, 1cm, 0.2cm, 0.1cm, 0deg, 4cm, 5cm, 0.5cm, 1cm) add(50, 17, 1cm, 0.2cm, 0.1cm, 0deg, 4cm, 5cm, 0.5cm, 1cm) add(50, 26, 1cm, 0.2cm, 0.1cm, 0deg, 4cm, 5cm, 0.5cm, 1cm) add(50, 34, 1cm, 0.2cm, 0.1cm, 0deg, 4cm, 5cm, 0.5cm, 1cm) add(50, 42, 1cm, 0.2cm, 0.1cm, 0deg, 4cm, 5cm, 0.5cm, 1cm) add(20, 1, 1cm, 0.2cm, 0.1cm, 0deg, 4cm, 5cm, 1cm, 1cm) add(20, 7, 1cm, 0.2cm, 0.1cm, 0deg, 4cm, 5cm, 1cm, 1cm) add(20, 14, 1cm, 0.2cm, 0.1cm, 0deg, 4cm, 5cm, 1cm, 1cm) add(30, 1, 1cm, 0.2cm, 0.1cm, 0deg, 4cm, 5cm, 1cm, 1cm) add(30, 8, 1cm, 0.2cm, 0.1cm, 0deg, 4cm, 5cm, 1cm, 1cm) add(30, 16, 1cm, 0.2cm, 0.1cm, 0deg, 4cm, 5cm, 1cm, 1cm)
  ParametricSetup15: Parametric Sim._Setups=[ATK_Solution]
    sweep $muscle_per: 30
    sweep $match_per: 23
    sweep circ_rad: 1cm
    sweep circ_wid: 0.2cm
    sweep port_gap: 0.1cm
    sweep turn_z: 0deg
    sweep muscle_dim: 4cm
    sweep match_dim: 5cm
    sweep match_wid: 1cm
    sweep surface_dim: 1cm
    table edits: add(40, 1, 1cm, 0.2cm, 0.1cm, 0deg, 4cm, 5cm, 1cm, 1cm) add(40, 9, 1cm, 0.2cm, 0.1cm, 0deg, 4cm, 5cm, 1cm, 1cm) add(40, 17, 1cm, 0.2cm, 0.1cm, 0deg, 4cm, 5cm, 1cm, 1cm) add(40, 24, 1cm, 0.2cm, 0.1cm, 0deg, 4cm, 5cm, 1cm, 1cm) add(40, 32, 1cm, 0.2cm, 0.1cm, 0deg, 4cm, 5cm, 1cm, 1cm) add(50, 1, 1cm, 0.2cm, 0.1cm, 0deg, 4cm, 5cm, 1cm, 1cm) add(50, 9, 1cm, 0.2cm, 0.1cm, 0deg, 4cm, 5cm, 1cm, 1cm) add(50, 17, 1cm, 0.2cm, 0.1cm, 0deg, 4cm, 5cm, 1cm, 1cm) add(50, 26, 1cm, 0.2cm, 0.1cm, 0deg, 4cm, 5cm, 1cm, 1cm) add(50, 34, 1cm, 0.2cm, 0.1cm, 0deg, 4cm, 5cm, 1cm, 1cm) add(50, 42, 1cm, 0.2cm, 0.1cm, 0deg, 4cm, 5cm, 1cm, 1cm)
  ParametricSetup16: Parametric Sim._Setups=[ATK_Solution]
    sweep $muscle_per: 20
    sweep $match_per: 1
    sweep circ_rad: 1.1cm
    sweep circ_wid: 0.2cm
    sweep port_gap: 0.1cm
    sweep turn_z: 0deg
    sweep muscle_dim: 4cm
    sweep match_dim: 5cm
    sweep match_wid: 0.5cm
    sweep surface_dim: 1cm
    table edits: add(20, 7, 1.1cm, 0.2cm, 0.1cm, 0deg, 4cm, 5cm, 0.5cm, 1cm) add(20, 14, 1.1cm, 0.2cm, 0.1cm, 0deg, 4cm, 5cm, 0.5cm, 1cm) add(30, 1, 1.1cm, 0.2cm, 0.1cm, 0deg, 4cm, 5cm, 0.5cm, 1cm) add(30, 8, 1.1cm, 0.2cm, 0.1cm, 0deg, 4cm, 5cm, 0.5cm, 1cm) add(30, 16, 1.1cm, 0.2cm, 0.1cm, 0deg, 4cm, 5cm, 0.5cm, 1cm) add(30, 23, 1.1cm, 0.2cm, 0.1cm, 0deg, 4cm, 5cm, 0.5cm, 1cm) add(40, 1, 1.1cm, 0.2cm, 0.1cm, 0deg, 4cm, 5cm, 0.5cm, 1cm) add(40, 9, 1.1cm, 0.2cm, 0.1cm, 0deg, 4cm, 5cm, 0.5cm, 1cm) add(40, 17, 1.1cm, 0.2cm, 0.1cm, 0deg, 4cm, 5cm, 0.5cm, 1cm) add(40, 24, 1.1cm, 0.2cm, 0.1cm, 0deg, 4cm, 5cm, 0.5cm, 1cm) add(40, 32, 1.1cm, 0.2cm, 0.1cm, 0deg, 4cm, 5cm, 0.5cm, 1cm)
  ParametricSetup17: Parametric Sim._Setups=[ATK_Solution]
    sweep $muscle_per: 50
    sweep $match_per: 1
    sweep circ_rad: 1.1cm
    sweep circ_wid: 0.2cm
    sweep port_gap: 0.1cm
    sweep turn_z: 0deg
    sweep muscle_dim: 4cm
    sweep match_dim: 5cm
    sweep match_wid: 0.5cm
    sweep surface_dim: 1cm
    table edits: add(50, 9, 1.1cm, 0.2cm, 0.1cm, 0deg, 4cm, 5cm, 0.5cm, 1cm) add(50, 17, 1.1cm, 0.2cm, 0.1cm, 0deg, 4cm, 5cm, 0.5cm, 1cm) add(50, 26, 1.1cm, 0.2cm, 0.1cm, 0deg, 4cm, 5cm, 0.5cm, 1cm) add(50, 34, 1.1cm, 0.2cm, 0.1cm, 0deg, 4cm, 5cm, 0.5cm, 1cm) add(50, 42, 1.1cm, 0.2cm, 0.1cm, 0deg, 4cm, 5cm, 0.5cm, 1cm) add(20, 1, 1.1cm, 0.2cm, 0.1cm, 0deg, 4cm, 5cm, 1cm, 1cm) add(20, 7, 1.1cm, 0.2cm, 0.1cm, 0deg, 4cm, 5cm, 1cm, 1cm) add(20, 14, 1.1cm, 0.2cm, 0.1cm, 0deg, 4cm, 5cm, 1cm, 1cm) add(30, 1, 1.1cm, 0.2cm, 0.1cm, 0deg, 4cm, 5cm, 1cm, 1cm) add(30, 8, 1.1cm, 0.2cm, 0.1cm, 0deg, 4cm, 5cm, 1cm, 1cm) add(30, 16, 1.1cm, 0.2cm, 0.1cm, 0deg, 4cm, 5cm, 1cm, 1cm)
  ParametricSetup18: Parametric Sim._Setups=[ATK_Solution]
    sweep $muscle_per: 30
    sweep $match_per: 23
    sweep circ_rad: 1.1cm
    sweep circ_wid: 0.2cm
    sweep port_gap: 0.1cm
    sweep turn_z: 0deg
    sweep muscle_dim: 4cm
    sweep match_dim: 5cm
    sweep match_wid: 1cm
    sweep surface_dim: 1cm
    table edits: add(40, 1, 1.1cm, 0.2cm, 0.1cm, 0deg, 4cm, 5cm, 1cm, 1cm) add(40, 9, 1.1cm, 0.2cm, 0.1cm, 0deg, 4cm, 5cm, 1cm, 1cm) add(40, 17, 1.1cm, 0.2cm, 0.1cm, 0deg, 4cm, 5cm, 1cm, 1cm) add(40, 24, 1.1cm, 0.2cm, 0.1cm, 0deg, 4cm, 5cm, 1cm, 1cm) add(40, 32, 1.1cm, 0.2cm, 0.1cm, 0deg, 4cm, 5cm, 1cm, 1cm) add(50, 1, 1.1cm, 0.2cm, 0.1cm, 0deg, 4cm, 5cm, 1cm, 1cm) add(50, 9, 1.1cm, 0.2cm, 0.1cm, 0deg, 4cm, 5cm, 1cm, 1cm) add(50, 17, 1.1cm, 0.2cm, 0.1cm, 0deg, 4cm, 5cm, 1cm, 1cm) add(50, 26, 1.1cm, 0.2cm, 0.1cm, 0deg, 4cm, 5cm, 1cm, 1cm) add(50, 34, 1.1cm, 0.2cm, 0.1cm, 0deg, 4cm, 5cm, 1cm, 1cm) add(50, 42, 1.1cm, 0.2cm, 0.1cm, 0deg, 4cm, 5cm, 1cm, 1cm)
radiation setups:
  3D: Infinite Sphere Theta=0deg..180deg step 2deg Phi=-180deg..180deg step 2deg
  Elevation: Infinite Sphere Theta=-180deg..180deg step 1deg Phi=0deg..90deg step 90deg
  Azimuth: Infinite Sphere Theta=90deg..90deg step 0deg Phi=-180deg..180deg step 1deg
  ATK_2D: Infinite Sphere Theta=-180deg..180deg step 1deg Phi=0deg..90deg step 90deg
  ATK_3D: Infinite Sphere Theta=-180deg..180deg step 2deg Phi=0deg..180deg step 5deg
field calculator expressions:
  Average_Power = Poynting | Mag | EnterSurface(Rectangle1) | SurfaceValue | Integrate | 1 | EnterSurface(Rectangle1) | SurfaceValue | Integrate | /
reports:
  ff_3D_GainTotal: dB(GainTotal) vs Phi, Theta on ATK_Solution : FF_Sweep, ATK_3D [Freq=2.4GHz]
  ff_2D_GainTotal: dB(GainTotal) vs Theta on ATK_Solution : FF_Sweep, ATK_2D [Phi=all Freq=2.4GHz]
  ff_2D_GainTotal_Stacked: dB(GainTotal) vs Theta on ATK_Solution : FF_Sweep, ATK_2D [Phi=all Freq=all]
  Return Loss: dB(St11) vs Freq on ATK_Solution : FF_Sweep [match_wid=all $match_per=all $muscle_per=all circ_rad=all circ_wid=all]
  Input Impedance: St11 on ATK_Solution : SParam_Sweep [Freq=all]; markers m1 at 2.4GHz
