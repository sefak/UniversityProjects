# Ansys Electronics Desktop project, version 2020.2
materials:
  pec: conductivity=1e+30
  vacuum: permittivity=1

design Torus_ATK (HFSS, DrivenTerminal, model units cm)
options: Allow_Material_Override open_region{BoundaryType=0 OpFreq=2.4GHz}
variables:
  # --Antenna Dimensions
  wire_rad = 0.1cm
  port_gap = 0.1cm
  torus_rad = 2.15cm
  turn_deg = (2*pi*torus_rad)/(2*pi*torus_rad+port_gap)*2*pi rad
geometry:
  RadiatingSurface [vacuum] = region(absolute_offset=4.1666667cm on all sides)
  Circle1 [pec] = circle(normal=Z, centre=(torus_rad, 0cm, 0cm), radius=wire_rad)
  Circle1.sweep_around_axis(axis=Y, angle=turn_deg)
  Polyline1 = polyline((torus_rad+wire_rad, 0cm, 0cm) (torus_rad-wire_rad, 0cm, 0cm))
  Polyline1.sweep_around_axis(axis=Y, angle=turn_deg-2*pi)
boundaries and excitations:
  AutoOpen1: Radiation Objects=RadiatingSurface
  Polyline1_T1: Terminal port=1 Edges=Polyline1.edge(#334) TerminalResistance=50ohm
  1: Lumped Port Faces=Polyline1.face Impedance=50ohm
setups:
  ATK_Solution: HfssDriven Frequency=2.4GHz MaxDeltaS=0.01 MaximumPasses=15 MinimumPasses=1 MinimumConvergedPasses=1 PercentRefinement=30 BasisOrder=1 PortAccuracy=2 IESolverType=ACA
    sweep FF_Sweep: 1.2GHz to 3.6GHz, 3 points; Type=Discrete SaveFields
    sweep SParam_Sweep: 1.5GHz to 3GHz, 501 points; Type=Interpolating InterpTolerance=0.5 InterpMaxSolns=250 PassivityErrorTolerance=0.0001
source amplitudes:
  1:1: 1V 0deg
radiation setups:
  3D: Infinite Sphere Theta=0deg..180deg step 2deg Phi=-180deg..180deg step 2deg
  Elevation: Infinite Sphere Theta=-180deg..180deg step 1deg Phi=0deg..90deg step 90deg
  Azimuth: Infinite Sphere Theta=90deg..90deg step 0deg Phi=-180deg..180deg step 1deg
  ATK_2D: Infinite Sphere Theta=-180deg..180deg step 1deg Phi=0deg..90deg step 90deg
  ATK_3D: Infinite Sphere Theta=-180deg..180deg step 2deg Phi=0deg..180deg step 5deg
reports:
  ff_3D_GainTotal: dB(GainTotal) vs Phi, Theta on ATK_Solution : LastAdaptive, ATK_3D [Freq=2.4e+09]
  ff_2D_GainTotal: dB(GainTotal) vs Theta on ATK_Solution : LastAdaptive, ATK_2D [Phi=all Freq=2.4e+09]
  ff_2D_GainTotal_Stacked: dB(GainTotal) vs Theta on ATK_Solution : FF_Sweep, ATK_2D [Phi=all Freq=all]
  Return Loss: dB(St11) vs Freq on ATK_Solution : SParam_Sweep [wire_rad=0.1cm port_gap=all torus_rad=2.15cm]
  Input Impedance: St11 on ATK_Solution : SParam_Sweep [Freq=all]
