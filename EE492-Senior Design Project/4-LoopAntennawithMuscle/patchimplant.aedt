# Ansys Electronics Desktop project, version 2020.2
materials:
  vacuum: permittivity=1
  Rogers RT/duroid 6006 (tm): permittivity=6.15 dielectric_loss_tangent=0.0019
  pec: conductivity=1e+30
  Teflon (tm): permittivity=2.1 dielectric_loss_tangent=0.001
  Muscle: permittivity=52.8 conductivity=1.71
  rubber_hard: permittivity=3 conductivity=1e-15
  matchmedium: permittivity=22
  gradedmaterial: permittivity=1
  gradedphantom: permittivity=50
  muscle2: permittivity=52.7 permeability=1 conductivity=1.7
  muscle3: permittivity=52.7 permeability=1 conductivity=1.7
  water_fresh: permittivity=81 permeability=0.999991 conductivity=0.01

design kas (HFSS, DrivenTerminal, model units cm)
options: Allow_Material_Override open_region{BoundaryType=0 OpFreq=2.5GHz}
variables:
  # --Antenna Dimensions
  patchX = 1cm
  patchY = 2.5cm
  # --Substrate Dimensions
  subH = 0.191cm
  subX = patchX+10*subH
  subY = patchY+10*subH
  # --Feed Dimensions
  feedX = 0cm
  feedY = 1cm
  coax_inner_rad = 0.05cm
  coax_outer_rad = 0.17cm
  feedLength = 1cm
  design_freq = 2.45GHz
  gnd_x = subX
  gnd_y = subY
  slotLength = 5cm
  subxoffset = -uslotoffset2-0.75mm-1.25mm-meandersubxoffset/2-9.5mm-1mm
  meandersubxoffset = (4.3+0.05+0.05-0.65-0.2) cm
  uslotoffset2 = -24.5mm
  subyoffset = dslotoffset2
  dslotoffset2 = 6mm
  xuzat = 24mm
  yuzat = 0mm
  port_gap = 0.094cm
  wire_rad = 0.094cm
  dipole_length = 2.12cm
  dipole_length_hava = 5.62cm
  turn_z = 0deg
  turn_deg = (2*pi*torus_rad)/(2*pi*torus_rad+port_gap)*2*pi rad
  torus_rad = 0.5cm
  wire_wid = 0.1cm
geometry:
  RadiatingSurface [vacuum] = region(absolute_offset=4cm on all sides)
  Box1 [Muscle] = box(corner=(-1.5*dipole_length_hava, -1.5*dipole_length_hava, dipole_length_hava), size=(3*dipole_length_hava, 3*dipole_length_hava, -2*dipole_length_hava))
  Rectangle1 [non-model] = rectangle(corner=(-patchX/2, -patchY/2, 0cm), x_size=patchX, y_size=patchY)
  Polyline1 = polyline(((torus_rad-wire_wid), 0, 0cm) (torus_rad, 0, 0cm))
  Polyline1.sweep_around_axis(axis=Z, angle=turn_deg-2*pi)
  Polyline1.rotate(axis=Z, angle=turn_z)
  Polyline2 = polyline((torus_rad-wire_wid, 0, 0cm) (torus_rad, 0, 0cm))
  Polyline2.sweep_around_axis(axis=Z, angle=turn_deg)
  Polyline2.rotate(axis=Z, angle=turn_z)
  [Polyline1, Polyline2].move(0cm, 0cm, dipole_length_hava)
boundaries and excitations:
  AutoOpen1: Radiation Objects=RadiatingSurface
  PerfE1: Perfect E Objects=Polyline2
  Polyline2_T1: Terminal port=1 Edges=Polyline2.edge(1 of 1) TerminalResistance=50ohm
  1: Lumped Port Faces=Polyline1.face(#849) Impedance=50ohm
setups:
  ATK_Solution: HfssDriven Frequency=2.5GHz MaxDeltaS=0.02 MaximumPasses=15 MinimumPasses=1 MinimumConvergedPasses=1 PercentRefinement=30 BasisOrder=1 PortAccuracy=2 IterativeResidual=1e-06 DDMSolverResidual=0.0001 IESolverType=ACA
    sweep FF_Sweep: point 2.4GHz; Type=Discrete SaveFields
    sweep SParam_Sweep: 1GHz to 3GHz, 201 points; Type=Interpolating InterpTolerance=0.5 InterpMaxSolns=250 PassivityErrorTolerance=0.0001
source amplitudes:
  1:1: 1V 0deg
optimetrics:
  ParametricSetup1: Parametric Sim._Setups=[ATK_Solution]
    sweep torus_rad: LIN 1.2cm 2.4cm 0.3cm
radiation setups:
  3D: Infinite Sphere Theta=0deg..180deg step 2deg Phi=-180deg..180deg step 2deg
  Elevation: Infinite Sphere Theta=-180deg..180deg step 1deg Phi=0deg..90deg step 90deg
  Azimuth: Infinite Sphere Theta=90deg..90deg step 0deg Phi=-180deg..180deg step 1deg
  ATK_2D: Infinite Sphere Theta=-180deg..180deg step 1deg Phi=0deg..90deg step 90deg
  ATK_3D: Infinite Sphere Theta=-180deg..180deg step 2deg Phi=0deg..180deg step 5deg
field calculator expressions:
  Average_Power = Poynting | Mag | EnterSurface(Rectangle1) | SurfaceValue | Integrate | 1 | EnterSurface(Rectangle1) | SurfaceValue | Integrate | /
reports:
  ff_3D_GainTotal: dB(GainTotal) vs Phi, Theta on ATK_Solution : LastAdaptive, ATK_3D [Freq=2.5GHz]
  ff_2D_GainTotal: dB(GainTotal) vs Theta on ATK_Solution : LastAdaptive, ATK_2D [Phi=all Freq=2.45e+09]
  ff_2D_GainTotal_Stacked: dB(GainTotal) vs Theta on ATK_Solution : FF_Sweep, ATK_2D [Phi=all Freq=all]
  Return Loss: dB(St11) vs Freq on ATK_Solution : SParam_Sweep [torus_rad=all wire_wid=0.1cm,0.2cm]
  Input Impedance: St11 on ATK_Solution : SParam_Sweep [Freq=all torus_rad=0.5cm wire_wid=0.1cm]; markers m1 at 2.4GHz, m2 at 2.4GHz
   Plot 1: dB(St11) vs Freq on ATK_Solution : SParam_Sweep [feedY=-1cm,-0.9cm,-0.8cm,0cm,0.1cm,0.2cm,0.3cm,0.4cm,0.5cm,0.6cm,0.7cm,0.8cm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]; markers m1 at 2.43GHz, m2 at 2.57GHz
   Plot 2: dB(St11) vs Freq on ATK_Solution : SParam_Sweep
   Plot 3: dB(St11) vs Freq on ATK_Solution : SParam_Sweep
   Plot 4: dB(St11) vs Freq on ATK_Solution : SParam_Sweep [patchX=0.8cm,0.9cm,1cm,1.1cm,1.2cm,1.4cm,1.6cm,3.2cm]; markers m1 at 2.51GHz, m2 at 2.3GHz, m3 at 2.43GHz, m4 at 2.43GHz

design kas_mm (HFSS, DrivenTerminal, model units cm)
options: Allow_Material_Override open_region{BoundaryType=0 OpFreq=2.5GHz}
variables:
  # --Antenna Dimensions
  patchX = 1cm
  patchY = 2.5cm
  # --Substrate Dimensions
  subH = 0.191cm
  subX = patchX+10*subH
  subY = patchY+10*subH
  # --Feed Dimensions
  feedX = 0cm
  feedY = 1cm
  coax_inner_rad = 0.05cm
  coax_outer_rad = 0.17cm
  feedLength = 1cm
  design_freq = 2.45GHz
  gnd_x = subX
  gnd_y = subY
  slotLength = 5cm
  subxoffset = -uslotoffset2-0.75mm-1.25mm-meandersubxoffset/2-9.5mm-1mm
  meandersubxoffset = (4.3+0.05+0.05-0.65-0.2) cm
  uslotoffset2 = -24.5mm
  subyoffset = dslotoffset2
  dslotoffset2 = 6mm
  xuzat = 24mm
  yuzat = 0mm
  port_gap = 0.094cm
  wire_rad = 0.094cm
  dipole_length = 2.595cm
  dipole_length_hava = 5.62cm
  torus_rad = 0.8cm
  turn_z = 0deg
  wire_wid = 0.1cm
  turn_deg = (2*pi*torus_rad)/(2*pi*torus_rad+port_gap)*2*pi rad
geometry:
  RadiatingSurface [vacuum] = region(absolute_offset=4cm on all sides)
  Box1 [Muscle] = box(corner=(-1.5*dipole_length_hava, -1.5*dipole_length_hava, dipole_length_hava), size=(3*dipole_length_hava, 3*dipole_length_hava, -2*dipole_length_hava))
  Box2 [matchmedium] = box(corner=(-5cm, -5cm, 5.62cm), size=(10cm, 10cm, 1cm))
  Rectangle1 [non-model] = rectangle(corner=(-patchX/2, -patchY/2, 0cm), x_size=patchX, y_size=patchY)
  Polyline1 = polyline(((torus_rad-wire_wid), 0, 0cm) (torus_rad, 0, 0cm))
  Polyline1.sweep_around_axis(axis=Z, angle=turn_deg-2*pi)
  Polyline1.rotate(axis=Z, angle=turn_z)
  Polyline1.move(0cm, 0cm, dipole_length_hava+1cm)
  Polyline2 = polyline((torus_rad-wire_wid, 0, 0cm) (torus_rad, 0, 0cm))
  Polyline2.sweep_around_axis(axis=Z, angle=turn_deg)
  Polyline2.rotate(axis=Z, angle=turn_z)
  Polyline2.move(0cm, 0cm, dipole_length_hava+1cm)
boundaries and excitations:
  AutoOpen1: Radiation Objects=RadiatingSurface
  PerfE1: Perfect E Objects=Polyline2
  Polyline2_T1: Terminal port=1 Edges=Polyline2.edge(1 of 1) TerminalResistance=50ohm
  1: Lumped Port Faces=Polyline1.face(#915) Impedance=50ohm
setups:
  ATK_Solution: HfssDriven Frequency=2.5GHz MaxDeltaS=0.02 MaximumPasses=15 MinimumPasses=1 MinimumConvergedPasses=1 PercentRefinement=30 BasisOrder=-1 PortAccuracy=2 IterativeResidual=1e-06 DDMSolverResidual=0.0001 IESolverType=ACA
    sweep FF_Sweep: point 2.4GHz; Type=Discrete SaveFields
    sweep SParam_Sweep: 1GHz to 3GHz, 201 points; Type=Interpolating InterpTolerance=0.5 InterpMaxSolns=250 PassivityErrorTolerance=0.0001
source amplitudes:
  1:1: 1 0deg
radiation setups:
  3D: Infinite Sphere Theta=0deg..180deg step 2deg Phi=-180deg..180deg step 2deg
  Elevation: Infinite Sphere Theta=-180deg..180deg step 1deg Phi=0deg..90deg step 90deg
  Azimuth: Infinite Sphere Theta=90deg..90deg step 0deg Phi=-180deg..180deg step 1deg
  ATK_2D: Infinite Sphere Theta=-180deg..180deg step 1deg Phi=0deg..90deg step 90deg
  ATK_3D: Infinite Sphere Theta=-180deg..180deg step 2deg Phi=0deg..180deg step 5deg
field calculator expressions:
  Average_Power = Poynting | Mag | EnterSurface(Rectangle1) | SurfaceValue | Integrate | 1 | EnterSurface(Rectangle1) | SurfaceValue | Integrate | /
field plots:
  Vector_RealPoynting1, Vector_RealPoynting2: Poynting over a plane on ATK_Solution : FF_Sweep at Freq=2.4GHz Phase=0deg
reports:
  ff_3D_GainTotal: dB(GainTotal) vs Phi, Theta on ATK_Solution : LastAdaptive, ATK_3D [Freq=2.45e+09]
  ff_2D_GainTotal: dB(GainTotal) vs Theta on ATK_Solution : LastAdaptive, ATK_2D [Phi=all Freq=2.45e+09]
  ff_2D_GainTotal_Stacked: dB(GainTotal) vs Theta on ATK_Solution : FF_Sweep, ATK_2D [Phi=all Freq=all]
  Return Loss: dB(St11) vs Freq on ATK_Solution : SParam_Sweep [torus_rad=0.7cm,0.8cm,1.2cm,1.5cm,1.8cm,2.1cm wire_wid=0.1cm]
  Input Impedance: St11 on ATK_Solution : SParam_Sweep [Freq=all torus_rad=0.7cm wire_wid=0.1cm]; markers m1 at 2.4GHz
   Plot 1: dB(St11) vs Freq on ATK_Solution : SParam_Sweep [feedY=-1cm,-0.9cm,-0.8cm,0cm,0.1cm,0.2cm,0.3cm,0.4cm,0.5cm,0.6cm,0.7cm,0.8cm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]; markers m1 at 2.43GHz, m2 at 2.57GHz
   Plot 2: dB(St11) vs Freq on ATK_Solution : SParam_Sweep
   Plot 3: dB(St11) vs Freq on ATK_Solution : SParam_Sweep
   Plot 4: dB(St11) vs Freq on ATK_Solution : SParam_Sweep [patchX=0.8cm,0.9cm,1cm,1.1cm,1.2cm,1.4cm,1.6cm,3.2cm]; markers m1 at 2.51GHz, m2 at 2.3GHz, m3 at 2.43GHz, m4 at 2.43GHz

design kas_mm_mn (HFSS, DrivenTerminal, model units cm)
options: Allow_Material_Override open_region{BoundaryType=0 OpFreq=2.5GHz}
variables:
  # --Antenna Dimensions
  patchX = 1cm
  patchY = 2.5cm
  # --Substrate Dimensions
  subH = 0.191cm
  subX = patchX+10*subH
  subY = patchY+10*subH
  # --Feed Dimensions
  feedX = 0cm
  feedY = 1cm
  coax_inner_rad = 0.05cm
  coax_outer_rad = 0.17cm
  feedLength = 1cm
  design_freq = 2.45GHz
  gnd_x = subX
  gnd_y = subY
  slotLength = 5cm
  subxoffset = -uslotoffset2-0.75mm-1.25mm-meandersubxoffset/2-9.5mm-1mm
  meandersubxoffset = (4.3+0.05+0.05-0.65-0.2) cm
  uslotoffset2 = -24.5mm
  subyoffset = dslotoffset2
  dslotoffset2 = 6mm
  xuzat = 24mm
  yuzat = 0mm
  port_gap = 0.094cm
  wire_rad = 0.094cm
  dipole_length = 2.595cm
  dipole_length_hava = 5.62cm
  torus_rad = 1.2cm
  turn_z = 0deg
  wire_wid = 0.2cm
  turn_deg = (2*pi*torus_rad)/(2*pi*torus_rad+port_gap)*2*pi rad
geometry:
  RadiatingSurface [vacuum] = region(absolute_offset=4cm on all sides)
  Box1 [Muscle] = box(corner=(-1.5*dipole_length_hava, -1.5*dipole_length_hava, dipole_length_hava), size=(3*dipole_length_hava, 3*dipole_length_hava, -2*dipole_length_hava))
  Box2 [matchmedium] = box(corner=(-5cm, -5cm, 5.62cm), size=(10cm, 10cm, 1cm))
  Rectangle1 [non-model] = rectangle(corner=(-patchX/2, -patchY/2, 0cm), x_size=patchX, y_size=patchY)
  Polyline1 = polyline(((torus_rad-wire_wid*0.5), 0, 0cm) (torus_rad, 0, 0cm))
  Polyline1.sweep_around_axis(axis=Z, angle=(turn_deg-2*pi)/2)
  Polyline1.rotate(axis=Z, angle=turn_z)
  Polyline1.move(0cm, 0cm, dipole_length_hava+1cm)
  Polyline2 = polyline((torus_rad-wire_wid, 0, 0cm) (torus_rad, 0, 0cm))
  Polyline2.sweep_around_axis(axis=Z, angle=turn_deg*0.999)
  Polyline2.rotate(axis=Z, angle=turn_z)
  Polyline2.move(0cm, 0cm, dipole_length_hava+1cm)
  Polyline3 = polyline(((torus_rad-wire_wid*0.5), 0, 0cm) (torus_rad, 0, 0cm))
  Polyline3.sweep_around_axis(axis=Z, angle=(turn_deg-2*pi)/2)
  Polyline3.rotate(axis=Z, angle=turn_z)
  Polyline3.rotate(axis=Z, angle=(turn_deg-2*pi)/2-turn_deg*0.001)
  Polyline3.move(0cm, 0cm, dipole_length_hava+1cm)
  Polyline4 = polyline(((torus_rad-wire_wid*0.5), 0, 0cm) (torus_rad, 0, 0cm))
  Polyline4.sweep_around_axis(axis=Z, angle=-turn_deg*0.001)
  Polyline4.rotate(axis=Z, angle=turn_z)
  Polyline4.rotate(axis=Z, angle=(turn_deg-2*pi)/2)
  Polyline4.move(0cm, 0cm, dipole_length_hava+1cm)
  Polyline5 = polyline(((torus_rad-wire_wid*0.51), 0, 0cm) (torus_rad-wire_wid, 0, 0cm))
  Polyline5.sweep_around_axis(axis=Z, angle=(turn_deg*0.999-2*pi))
  Polyline5.rotate(axis=Z, angle=turn_z)
  Polyline5.move(0cm, 0cm, dipole_length_hava+1cm)
boundaries and excitations:
  AutoOpen1: Radiation Objects=RadiatingSurface
  PerfE1: Perfect E Objects=Polyline2
  LumpL1: Lumped RLC Objects=Polyline3 CurrentLine{Polyline3.vertex(2 of 2) -> Polyline3.vertex(#947)} RLC_Type=Parallel Inductance=2nH
  PerfE2: Perfect E Objects=Polyline4
  LumpC1: Lumped RLC Objects=Polyline5 CurrentLine{Polyline5.vertex(2 of 2) -> Polyline5.vertex(#991)} RLC_Type=Parallel Capacitance=0.1pF
  Polyline2_T1: Terminal port=1 Edges=Polyline2.edge(1 of 1) TerminalResistance=50ohm
  1: Lumped Port Faces=Polyline1.face(#915) Impedance=50ohm
setups:
  ATK_Solution: HfssDriven Frequency=2.5GHz MaxDeltaS=0.02 MaximumPasses=15 MinimumPasses=1 MinimumConvergedPasses=1 PercentRefinement=30 BasisOrder=-1 PortAccuracy=2 IterativeResidual=1e-06 DDMSolverResidual=0.0001 IESolverType=ACA
    sweep FF_Sweep: point 2.4GHz; Type=Discrete SaveFields
    sweep SParam_Sweep: 2GHz to 3GHz, 201 points; Type=Interpolating InterpTolerance=0.5 InterpMaxSolns=250 PassivityErrorTolerance=0.0001
source amplitudes:
  1:1: 1V 0deg
radiation setups:
  3D: Infinite Sphere Theta=0deg..180deg step 2deg Phi=-180deg..180deg step 2deg
  Elevation: Infinite Sphere Theta=-180deg..180deg step 1deg Phi=0deg..90deg step 90deg
  Azimuth: Infinite Sphere Theta=90deg..90deg step 0deg Phi=-180deg..180deg step 1deg
  ATK_2D: Infinite Sphere Theta=-180deg..180deg step 1deg Phi=0deg..90deg step 90deg
  ATK_3D: Infinite Sphere Theta=-180deg..180deg step 2deg Phi=0deg..180deg step 5deg
field calculator expressions:
  Average_Power = Poynting | Mag | EnterSurface(Rectangle1) | SurfaceValue | Integrate | 1 | EnterSurface(Rectangle1) | SurfaceValue | Integrate | /
reports:
  ff_3D_GainTotal: dB(GainTotal) vs Phi, Theta on ATK_Solution : LastAdaptive, ATK_3D [Freq=2.45e+09]
  ff_2D_GainTotal: dB(GainTotal) vs Theta on ATK_Solution : LastAdaptive, ATK_2D [Phi=all Freq=2.45e+09]
  ff_2D_GainTotal_Stacked: dB(GainTotal) vs Theta on ATK_Solution : FF_Sweep, ATK_2D [Phi=all Freq=all]
  Return Loss: dB(St11) vs Freq on ATK_Solution : SParam_Sweep
  Input Impedance: St11 on ATK_Solution : SParam_Sweep [Freq=all]; markers m1 at 2.4GHz
   Plot 1: dB(St11) vs Freq on ATK_Solution : SParam_Sweep [feedY=-1cm,-0.9cm,-0.8cm,0cm,0.1cm,0.2cm,0.3cm,0.4cm,0.5cm,0.6cm,0.7cm,0.8cm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]; markers m1 at 2.43GHz, m2 at 2.57GHz
   Plot 2: dB(St11) vs Freq on ATK_Solution : SParam_Sweep
   Plot 3: dB(St11) vs Freq on ATK_Solution : SParam_Sweep
   Plot 4: dB(St11) vs Freq on ATK_Solution : SParam_Sweep [patchX=0.8cm,0.9cm,1cm,1.1cm,1.2cm,1.4cm,1.6cm,3.2cm]; markers m1 at 2.51GHz, m2 at 2.3GHz, m3 at 2.43GHz, m4 at 2.43GHz

design kas_mn (HFSS, DrivenTerminal, model units cm)
options: Allow_Material_Override open_region{BoundaryType=0 OpFreq=2.5GHz}
variables:
  # --Antenna Dimensions
  patchX = 1cm
  patchY = 2.5cm
  # --Substrate Dimensions
  subH = 0.191cm
  subX = patchX+10*subH
  subY = patchY+10*subH
  # --Feed Dimensions
  feedX = 0cm
  feedY = 1cm
  coax_inner_rad = 0.05cm
  coax_outer_rad = 0.17cm
  feedLength = 1cm
  design_freq = 2.45GHz
  gnd_x = subX
  gnd_y = subY
  slotLength = 5cm
  subxoffset = -uslotoffset2-0.75mm-1.25mm-meandersubxoffset/2-9.5mm-1mm
  meandersubxoffset = (4.3+0.05+0.05-0.65-0.2) cm
  uslotoffset2 = -24.5mm
  subyoffset = dslotoffset2
  dslotoffset2 = 6mm
  xuzat = 24mm
  yuzat = 0mm
  port_gap = 0.094cm
  wire_rad = 0.094cm
  dipole_length = 2.12cm
  dipole_length_hava = 5.62cm
  torus_rad = 1.5cm
  wire_wid = 0.2cm
  turn_z = 2deg
  turn_deg = (2*pi*torus_rad)/(2*pi*torus_rad+port_gap)*2*pi rad
geometry:
  RadiatingSurface [vacuum] = region(absolute_offset=4cm on all sides)
  Box1 [Muscle] = box(corner=(-1.5*dipole_length_hava, -1.5*dipole_length_hava, dipole_length_hava), size=(3*dipole_length_hava, 3*dipole_length_hava, -2*dipole_length_hava))
  Rectangle1 [non-model] = rectangle(corner=(-patchX/2, -patchY/2, 0cm), x_size=patchX, y_size=patchY)
  Polyline1 = polyline(((torus_rad-wire_wid*0.5), 0, 0cm) (torus_rad, 0, 0cm))
  Polyline1.sweep_around_axis(axis=Z, angle=(turn_deg-2*pi)/2)
  Polyline1.rotate(axis=Z, angle=turn_z)
  Polyline2 = polyline((torus_rad-wire_wid, 0, 0cm) (torus_rad, 0, 0cm))
  Polyline2.sweep_around_axis(axis=Z, angle=turn_deg*0.999)
  Polyline2.rotate(axis=Z, angle=turn_z)
  Polyline3 = polyline(((torus_rad-wire_wid), 0, 0cm) (torus_rad, 0, 0cm))
  Polyline3.sweep_around_axis(axis=Z, angle=(turn_deg-2*pi)/2)
  Polyline3.rotate(axis=Z, angle=turn_z)
  Polyline3.rotate(axis=Z, angle=(turn_deg-2*pi)/2-turn_deg*0.001)
  Polyline4 = polyline(((torus_rad-wire_wid), 0, 0cm) (torus_rad, 0, 0cm))
  Polyline4.sweep_around_axis(axis=Z, angle=-turn_deg*0.001)
  Polyline4.rotate(axis=Z, angle=turn_z)
  Polyline4.rotate(axis=Z, angle=(turn_deg-2*pi)/2)
  Polyline5 = polyline(((torus_rad-wire_wid*0.51), 0, 0cm) (torus_rad-wire_wid, 0, 0cm))
  Polyline5.sweep_around_axis(axis=Z, angle=(turn_deg-2*pi)/2)
  Polyline5.rotate(axis=Z, angle=turn_z)
  [Polyline1..Polyline5].move(0cm, 0cm, dipole_length_hava)
boundaries and excitations:
  AutoOpen1: Radiation Objects=RadiatingSurface
  PerfE1: Perfect E Objects=Polyline2
  LumpC1: Lumped RLC Objects=Polyline3 CurrentLine{Polyline3.vertex(2 of 2) -> Polyline3.vertex(#879)} RLC_Type=Parallel Capacitance=8pF
  PerfE2: Perfect E Objects=Polyline4
  LumpL1: Lumped RLC Objects=Polyline5 CurrentLine{Polyline5.vertex(2 of 2) -> Polyline5.vertex(#907)} RLC_Type=Parallel Inductance=4nH
  Polyline2_T1: Terminal port=1 Edges=Polyline2.edge(1 of 1) TerminalResistance=50ohm
  1: Lumped Port Faces=Polyline1.face(#849) Impedance=50ohm
setups:
  ATK_Solution: HfssDriven Frequency=2.5GHz MaxDeltaS=0.02 MaximumPasses=15 MinimumPasses=1 MinimumConvergedPasses=1 PercentRefinement=30 BasisOrder=1 PortAccuracy=2 IterativeResidual=1e-06 DDMSolverResidual=0.0001 IESolverType=ACA
    sweep FF_Sweep: point 2.4GHz; Type=Discrete SaveFields
    sweep SParam_Sweep: 2GHz to 3GHz, 201 points; Type=Interpolating InterpTolerance=0.5 InterpMaxSolns=250 PassivityErrorTolerance=0.0001
source amplitudes:
  1:1: 1V 0deg
radiation setups:
  3D: Infinite Sphere Theta=0deg..180deg step 2deg Phi=-180deg..180deg step 2deg
  Elevation: Infinite Sphere Theta=-180deg..180deg step 1deg Phi=0deg..90deg step 90deg
  Azimuth: Infinite Sphere Theta=90deg..90deg step 0deg Phi=-180deg..180deg step 1deg
  ATK_2D: Infinite Sphere Theta=-180deg..180deg step 1deg Phi=0deg..90deg step 90deg
  ATK_3D: Infinite Sphere Theta=-180deg..180deg step 2deg Phi=0deg..180deg step 5deg
field calculator expressions:
  Average_Power = Poynting | Mag | EnterSurface(Rectangle1) | SurfaceValue | Integrate | 1 | EnterSurface(Rectangle1) | SurfaceValue | Integrate | /
reports:
  ff_3D_GainTotal: dB(GainTotal) vs Phi, Theta on ATK_Solution : LastAdaptive, ATK_3D [Freq=2.45e+09]
  ff_2D_GainTotal: dB(GainTotal) vs Theta on ATK_Solution : LastAdaptive, ATK_2D [Phi=all Freq=2.45e+09]
  ff_2D_GainTotal_Stacked: dB(GainTotal) vs Theta on ATK_Solution : FF_Sweep, ATK_2D [Phi=all Freq=all]
  Return Loss: dB(St11) vs Freq on ATK_Solution : SParam_Sweep; markers m1 at 2.404GHz
  Input Impedance: St11 on ATK_Solution : SParam_Sweep [Freq=all]; markers m1 at 2.4GHz
   Plot 1: dB(St11) vs Freq on ATK_Solution : SParam_Sweep [feedY=-1cm,-0.9cm,-0.8cm,0cm,0.1cm,0.2cm,0.3cm,0.4cm,0.5cm,0.6cm,0.7cm,0.8cm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]; markers m1 at 2.43GHz, m2 at 2.57GHz
   Plot 2: dB(St11) vs Freq on ATK_Solution : SParam_Sweep
   Plot 3: dB(St11) vs Freq on ATK_Solution : SParam_Sweep
   Plot 4: dB(St11) vs Freq on ATK_Solution : SParam_Sweep [patchX=0.8cm,0.9cm,1cm,1.1cm,1.2cm,1.4cm,1.6cm,3.2cm]; markers m1 at 2.51GHz, m2 at 2.3GHz, m3 at 2.43GHz, m4 at 2.43GHz
