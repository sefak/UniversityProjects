# Ansys Electronics Desktop project, version 2020.2
materials:
  vacuum: permittivity=1

design CircularLoop_ATK (HFSS, DrivenTerminal, model units cm)
options: Allow_Material_Override open_region{BoundaryType=0 OpFreq=2.5GHz}
variables:
  # --Antenna Dimensions
  port_gap = 0.1cm
  torus_rad = 2.1cm
  turn_deg = (2*pi*torus_rad)/(2*pi*torus_rad+port_gap)*2*pi rad
  wire_wid = 0.3cm
  turn_z = 0deg
geometry:
  RadiatingSurface [vacuum] = region(absolute_offset=4cm on all sides)
  Polyline1 = polyline(((torus_rad-wire_wid), 0, 0cm) (torus_rad, 0, 0cm))
  Polyline1.sweep_around_axis(axis=Z, angle=turn_deg-2*pi)
  Polyline2 = polyline((torus_rad-wire_wid, 0, 0cm) (torus_rad, 0, 0cm))
  Polyline2.sweep_around_axis(axis=Z, angle=turn_deg)
  [Polyline2, Polyline1].rotate(axis=Z, angle=turn_z)
boundaries and excitations:
  AutoOpen1: Radiation Objects=RadiatingSurface
  PerfE1: Perfect E Objects=Polyline2
  Polyline2_T1: Terminal port=1 Edges=Polyline2.edge(1 of 1) TerminalResistance=50ohm
  1: Lumped Port Faces=Polyline1.face(#333) Impedance=50ohm
setups:
  ATK_Solution: HfssDriven Frequency=2.5GHz MaxDeltaS=0.01 MaximumPasses=15 MinimumPasses=1 MinimumConvergedPasses=1 PercentRefinement=30 BasisOrder=1 PortAccuracy=2 IESolverType=ACA
    sweep FF_Sweep: 1.2GHz to 3.6GHz, 3 points; Type=Discrete SaveFields
    sweep SParam_Sweep: 2GHz to 5GHz, 401 points; Type=Interpolating InterpTolerance=0.5 InterpMaxSolns=250 PassivityErrorTolerance=0.0001
source amplitudes:
  1:1: 1 0deg
radiation setups:
  3D: Infinite Sphere Theta=0deg..180deg step 2deg Phi=-180deg..180deg step 2deg
  Elevation: Infinite Sphere Theta=-180deg..180deg step 1deg Phi=0deg..90deg step 90deg
  Azimuth: Infinite Sphere Theta=90deg..90deg step 0deg Phi=-180deg..180deg step 1deg
  ATK_2D: Infinite Sphere Theta=-180deg..180deg step 1deg Phi=0deg..90deg step 90deg
  ATK_3D: Infinite Sphere Theta=-180deg..180deg step 2deg Phi=0deg..180deg step 5deg
reports:
  ff_3D_GainTotal: dB(GainTotal) vs Phi, Theta on ATK_Solution : LastAdaptive, ATK_3D [Freq=2.4e+09]
  ff_2D_GainTotal: dB(GainTotal) vs Theta on ATK_Solution : LastAdaptive, ATK_2D [Phi=all Freq=2.4e+09]
  ff_2D_GainTotal_Stacked: dB(GainTotal) vs Theta on ATK_Solution : FF_Sweep, ATK_2D [Phi=all Freq=all]
  Return Loss: dB(St11) vs Freq on ATK_Solution : SParam_Sweep
  Input Impedance: St11 on ATK_Solution : SParam_Sweep [Freq=all]; markers m1 at 2.41GHz

design CircularLoopwithMatchingNetwork_ATK (HFSS, DrivenTerminal, model units cm)
options: Allow_Material_Override open_region{BoundaryType=0 OpFreq=2.5GHz}
variables:
  # --Antenna Dimensions
  port_gap = 0.1cm
  torus_rad = 2.1cm
  turn_deg = (2*pi*torus_rad)/(2*pi*torus_rad+port_gap)*2*pi rad
  wire_wid = 0.3cm
  turn_z = 0deg
geometry:
  RadiatingSurface [vacuum] = region(absolute_offset=4cm on all sides)
  Polyline1 = polyline(((torus_rad-wire_wid*0.5), 0, 0cm) (torus_rad, 0, 0cm))
  Polyline1.sweep_around_axis(axis=Z, angle=(turn_deg-2*pi)/2)
  Polyline2 = polyline((torus_rad-wire_wid, 0, 0cm) (torus_rad, 0, 0cm))
  Polyline2.sweep_around_axis(axis=Z, angle=turn_deg*0.999)
  [Polyline2, Polyline1].rotate(axis=Z, angle=turn_z)
  Polyline3 = polyline(((torus_rad-wire_wid*0.5), 0, 0cm) (torus_rad, 0, 0cm))
  Polyline3.sweep_around_axis(axis=Z, angle=(turn_deg-2*pi)/2)
  Polyline3.rotate(axis=Z, angle=turn_z)
  Polyline3.rotate(axis=Z, angle=(turn_deg-2*pi)/2-turn_deg*0.001)
  Polyline4 = polyline(((torus_rad-wire_wid*0.5), 0, 0cm) (torus_rad, 0, 0cm))
  Polyline4.sweep_around_axis(axis=Z, angle=-turn_deg*0.001)
  Polyline4.rotate(axis=Z, angle=turn_z)
  Polyline4.rotate(axis=Z, angle=(turn_deg-2*pi)/2)
  Polyline5 = polyline(((torus_rad-wire_wid*0.51), 0, 0cm) (torus_rad-wire_wid, 0, 0cm))
  Polyline5.sweep_around_axis(axis=Z, angle=(turn_deg*0.999-2*pi))
  Polyline5.rotate(axis=Z, angle=turn_z)
boundaries and excitations:
  AutoOpen1: Radiation Objects=RadiatingSurface
  PerfE1: Perfect E Objects=Polyline2
  PerfE2: Perfect E Objects=Polyline4
  LumpL1: Lumped RLC Objects=Polyline3 CurrentLine{Polyline3.vertex(2 of 2) -> Polyline3.vertex(#472)} RLC_Type=Parallel Inductance=6nH
  LumpC1: Lumped RLC Objects=Polyline5 CurrentLine{Polyline5.vertex(2 of 2) -> Polyline5.vertex(#513)} RLC_Type=Parallel Capacitance=0.2pF
  Polyline2_T1: Terminal port=1 Edges=Polyline2.edge(1 of 1) TerminalResistance=50ohm
  1: Lumped Port Faces=Polyline1.face(#333) Impedance=50ohm
setups:
  ATK_Solution: HfssDriven Frequency=2.5GHz MaxDeltaS=0.01 MaximumPasses=15 MinimumPasses=1 MinimumConvergedPasses=1 PercentRefinement=30 BasisOrder=1 PortAccuracy=2 IESolverType=ACA
    sweep FF_Sweep: point 2.41GHz; Type=Discrete SaveFields
    sweep SParam_Sweep: 2GHz to 3GHz, 401 points; Type=Interpolating InterpTolerance=0.5 InterpMaxSolns=250 PassivityErrorTolerance=0.0001
source amplitudes:
  1:1: 1 0deg
optimetrics:
  ParametricSetup1: Parametric Sim._Setups=[ATK_Solution]
    sweep port_gap: 0.05cm 0.2cm
  ParametricSetup2: Parametric Sim._Setups=[ATK_Solution]
    sweep torus_rad: 1.9cm 2.3cm
  ParametricSetup3: Parametric Sim._Setups=[ATK_Solution]
    sweep wire_wid: 0.2cm 0.4cm
radiation setups:
  3D: Infinite Sphere Theta=0deg..180deg step 2deg Phi=-180deg..180deg step 2deg
  Elevation: Infinite Sphere Theta=-180deg..180deg step 1deg Phi=0deg..90deg step 90deg
  Azimuth: Infinite Sphere Theta=90deg..90deg step 0deg Phi=-180deg..180deg step 1deg
  ATK_2D: Infinite Sphere Theta=-180deg..180deg step 1deg Phi=0deg..90deg step 90deg
  ATK_3D: Infinite Sphere Theta=-180deg..180deg step 2deg Phi=0deg..180deg step 5deg
reports:
  ff_3D_GainTotal: dB(GainTotal) vs Phi, Theta on ATK_Solution : LastAdaptive, ATK_3D [Freq=2.5GHz]
  ff_2D_GainTotal: dB(GainTotal) vs Theta on ATK_Solution : LastAdaptive, ATK_2D [Phi=all Freq=2.5GHz]
  ff_2D_GainTotal_Stacked: dB(GainTotal) vs Theta on ATK_Solution : FF_Sweep, ATK_2D [Phi=all Freq=all]
  Return Loss: dB(St11) vs Freq on ATK_Solution : SParam_Sweep; markers m1 at 2.41GHz
  Input Impedance: St11 on ATK_Solution : SParam_Sweep [Freq=all]; markers m1 at 2.41GHz
